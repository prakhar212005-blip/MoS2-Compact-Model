simulator lang=spectre

ahdl_include "mos2_fet.vams"

global 0
options option scale=1

Vds  (d  0)  vsource  dc=Vds_val  type=dc
Vgs  (g  0)  vsource  dc=0        type=dc

M1 (d g 0 0) mos2_fet
+   L=500e-9
+   W=1e-6
+   mu0=185e-4
+   Vg0=-1.75
+   alpha=4.2
+   vsat=1.55e4
+   nu=1.45
+   m_sat=7.4
+   lambda_clm=0.003
+   DIBL_coeff=0.0

parameters Vds_val=0.05

xfer_500nm  dc  dev=Vgs  start=-3.5  stop=1.5  step=0.01 \
    paramset=vds_sweep  save=selected \
    restoredefaults=yes

vds_sweep  paramset {
    Vds_val
    0.05
    0.2
    0.6
    1.0
}

save  Vgs:p  M1:d
